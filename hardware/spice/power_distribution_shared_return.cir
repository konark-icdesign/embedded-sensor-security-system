* Rev-C comparison case: BAD shared alarm + analog return.
* Same source/load envelope as power_distribution_star.cir, but the 0.5 A
* alarm current and microphone/analog return share a 0.10 ohm return path.

VADAPTER src 0 12
R_SOURCE src vin 0.25
R_BULK_ESR vin cbulk 0.05
C_BULK cbulk 0 470u

R_GND_UNO g_uno 0 0.03
R_GND_PWR g_power 0 0.03
R_GND_SHARED g_shared 0 0.10

I_UNO vin g_uno PULSE(0.12 0.25 14m 10u 10u 2m 40m)
I_BUCK_IN vin g_power PULSE(0.07 0.47 10m 20u 20u 5m 40m)
I_ALARM vin g_shared PULSE(0 0.50 12m 10u 10u 5m 40m)

V_REG regsrc g_power 5.0
R_REG regsrc rail5 0.060
R_COUT_ESR rail5 cout_node 0.005
C_COUT cout_node g_power 44u
I_SENSOR rail5 g_power PULSE(0.15 1.00 10m 20u 20u 5m 40m)

R_ANALOG_FEED rail5 ana5 10
C_ANALOG_BULK ana5 g_shared 220u
C_ANALOG_HF ana5 g_shared 100n
I_ANALOG ana5 g_shared 0.004

* Explicit differential-probe nodes for ngspice .meas compatibility.
E_RAIL5_REL rail5_rel 0 rail5 g_power 1
E_ANALOG5_REL analog5_rel 0 ana5 g_shared 1
E_SHARED_GND_REL shared_gnd_rel 0 g_shared g_power 1

.tran 2u 30m

.meas tran vin_min MIN v(vin) FROM=9m TO=20m
.meas tran rail5_min MIN v(rail5_rel) FROM=9m TO=20m
.meas tran analog5_min MIN v(analog5_rel) FROM=9m TO=20m
.meas tran shared_ground_peak MAX v(shared_gnd_rel) FROM=9m TO=20m
.meas tran shared_ground_quiet FIND v(shared_gnd_rel) AT=11m
.meas tran shared_ground_alarm FIND v(shared_gnd_rel) AT=14m

.end
